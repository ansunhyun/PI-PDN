# Ansys Electronics Desktop project, version 2025.2
materials:
  air: permittivity=1.0006
  copper: permeability=0.999991 conductivity=58000000
  FR4_epoxy: permittivity=4.4 dielectric_loss_tangent=0.02
  pec: permeability=1 conductivity=1e+30
  solder: permeability=1 conductivity=7000000

design EAX02034601_stackup_bootstrap (HFSS 3D Layout)
nets:
  +1.2V_DDR: port PORT_IC100_1_2V_DDR
  +CPU_1V0: port PORT_IC100_CPU_1V0
  +D1V0: port PORT_IC100_D1V0
  SIGN003116: port PORT_IC100_PIF1V5
ports:
  PORT_IC100_1_2V_DDR: Properties{Override_Impedance Impedance=0.1 Magnitude=0V Phase=0deg Renormalize_Impedance=50ohm Deembed_Distance=0mm Layer_Alignment=Upper Horizontal_Extent_Factor=5 Vertical_Extent_Factor=3 PEC_Launch_Width=0mm Reference_Net=GND} Type=EdgePort Pin=PORT_IC100_1_2V_DDR
  PORT_IC100_CPU_1V0: Properties{Override_Impedance Impedance=0.1 Magnitude=0V Phase=0deg Renormalize_Impedance=50ohm Deembed_Distance=0mm Layer_Alignment=Upper Horizontal_Extent_Factor=5 Vertical_Extent_Factor=3 PEC_Launch_Width=0mm Reference_Net=GND} Type=EdgePort Pin=PORT_IC100_CPU_1V0
  PORT_IC100_D1V0: Properties{Override_Impedance Impedance=0.1 Magnitude=0V Phase=0deg Renormalize_Impedance=50ohm Deembed_Distance=0mm Layer_Alignment=Upper Horizontal_Extent_Factor=5 Vertical_Extent_Factor=3 PEC_Launch_Width=0mm Reference_Net=GND} Type=EdgePort Pin=PORT_IC100_D1V0
  PORT_IC100_PIF1V5: Properties{Override_Impedance Impedance=0.1 Magnitude=0V Phase=0deg Renormalize_Impedance=50ohm Deembed_Distance=0mm Layer_Alignment=Upper Horizontal_Extent_Factor=5 Vertical_Extent_Factor=3 PEC_Launch_Width=0mm Reference_Net=GND} Type=EdgePort Pin=PORT_IC100_PIF1V5
